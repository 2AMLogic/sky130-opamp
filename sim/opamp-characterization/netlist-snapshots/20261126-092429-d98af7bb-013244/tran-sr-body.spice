* opamp_core unity-gain-buffer slew-rate testbench, `klt sim` circuit BODY (issues #17, #77, #278)
*
* Measures `design/netlist/opamp_core.spice`'s large-signal slew rate into
* CL = 2 pF [DR-001], via the classic 20 %-80 % unity-gain-buffer step
* response. klt supplies the .lib/.temp/alter-vdd cards and the .control
* block; the analysis and the `.meas` cards live in the request
* (bin/pvt_sweep.py build_klt_request).
*
* Feedback: `inn` is wired directly to `out` through a negligible-resistance
* resistor (Rshort, 1 mOhm -- ngspice will not accept a literal zero-ohm
* two-terminal element in some analysis modes, so a small non-zero value
* stands in for a wire) -- a real physical unity-gain-buffer connection,
* not the AC bench's DC-servo artifice, since this is a genuine large-signal
* closed-loop transient, not an open-loop small-signal one.
*
* Stimulus: `inp` steps between 0.3*VDD and 0.7*VDD (a fixed fraction of
* VDD around mid-supply, chosen in bin/pvt_sweep.py so the same relative
* stimulus scales with each corner's own supply -- see ../README.md
* "Stimulus choices") with a fast 1 ns edge, well inside the linear input
* range this experiment's own opamp_dc_swing.klt.spice.tmpl bench confirms
* independently. The levels scale with each corner's own VDD (`alter vdd`)
* through behavioural sources, so one request carries the whole supply axis:
*   Vp      unit pulse (0 -> 1), the only explicit transient source
*   Bin     inp = VDD * (0.3 + 0.4 * Vp)
*   Bl20/80 trigger levels  V_LOW + 0.2*span, V_LOW + 0.8*span
*
* Measurement: `.meas ... when v(out)=v(level)` times the 20 %-80 % (rise)
* and 80 %-20 % (fall) transit of `v(out)` between the step's low and high
* levels -- the textbook slew-rate measurement convention -- so
* SR = 0.6*(V_HIGH-V_LOW) / measured_time in each direction.
* bin/pvt_sweep.py derives the row from the measured crossing times.

.option scale=1u

.subckt opamp_dut vdd vss inn inp out ibias
.include "opamp_core.spice"
.ends opamp_dut

Vdd vdd 0 dc 1.8
Vss vss 0 dc 0
Iref vdd ibias dc 5u
Xdut vdd vss inn inp out ibias opamp_dut
Rshort inn out 1m
Vp p 0 pulse(0 1 200n 1n 1n 1u 2u)
Bin inp 0 V = v(vdd)*(0.3+0.4*v(p))
Bl20 l20 0 V = v(vdd)*(0.3+0.4*0.2)
Bl80 l80 0 V = v(vdd)*(0.3+0.4*0.8)
Cload out 0 2p
