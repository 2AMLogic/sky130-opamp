* klt sim -- generated corner deck, do not edit
.lib /home/ubuntu/.volare/sky130A/libs.tech/ngspice/sky130.lib.spice tt
.include /tmp/opamp-klt-sr-xq6679tp/tran-sr-icmr-tt-27C-1.8V-body.spice
.temp 27.0
.meas tran vout_pre_v find v(out) at=190n
.control
save all
alter vdd=1.8
set filetype=ascii
tran 2n 2.2u
write /home/ubuntu/GitHub/sky130-opamp/.loom/worktrees/issue-185/sim/opamp-characterization/records/20261011-201655-046fe81-7349fb-logs/klt-tran-sr-icmr-tt-27C-1.8V/tt_1p800V_27C/waveform.raw
quit
.endc
.end
