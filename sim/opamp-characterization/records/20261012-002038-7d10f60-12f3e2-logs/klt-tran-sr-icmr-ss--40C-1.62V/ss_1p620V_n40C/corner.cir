* klt sim -- generated corner deck, do not edit
.lib /opt/pdk/sky130A/libs.tech/ngspice/sky130.lib.spice ss
.include /var/tmp/eda-job-klt-sim-c7240352da00/inputs/netlist.cir
.temp -40.0
.meas tran vout_pre_v find v(out) at=190n
.control
alter vdd=1.62
set filetype=ascii
tran 2n 2.2u
write /var/tmp/eda-job-klt-sim-c7240352da00/outputs/artifacts/ss_1p620V_n40C/waveform.raw
quit
.endc
.end
