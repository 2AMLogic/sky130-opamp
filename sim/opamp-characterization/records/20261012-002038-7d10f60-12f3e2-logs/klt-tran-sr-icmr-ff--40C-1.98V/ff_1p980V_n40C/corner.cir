* klt sim -- generated corner deck, do not edit
.lib /opt/pdk/sky130A/libs.tech/ngspice/sky130.lib.spice ff
.include /var/tmp/eda-job-klt-sim-0ca0b5b4df7e/inputs/netlist.cir
.temp -40.0
.meas tran vout_pre_v find v(out) at=190n
.control
alter vdd=1.98
set filetype=ascii
tran 2n 2.2u
write /var/tmp/eda-job-klt-sim-0ca0b5b4df7e/outputs/artifacts/ff_1p980V_n40C/waveform.raw
quit
.endc
.end
