* klt sim -- generated corner deck, do not edit
.lib /opt/pdk/sky130A/libs.tech/ngspice/sky130.lib.spice ff
.include /var/tmp/eda-job-klt-sim-c8af25771328/inputs/netlist.cir
.temp 27.0
.meas tran vout_pre_v find v(out) at=190n
.control
alter vdd=1.98
set filetype=ascii
tran 2n 2.2u
write /var/tmp/eda-job-klt-sim-c8af25771328/outputs/artifacts/ff_1p980V_27C/waveform.raw
quit
.endc
.end
