* klt sim -- generated corner deck, do not edit
.lib /home/ubuntu/.volare/sky130A/libs.tech/ngspice/sky130.lib.spice tt
.include /tmp/opamp-klt-ydkg4b8z/tran-step-body.spice
.temp 27.0
.meas tran v_init find v(out) at=1.9e-07
.meas tran v_ofs find v(ofs) at=1.9e-07
.meas tran v_final find v(out) at=4e-06
.meas tran v_peak max v(out) from=2e-07 to=4e-06
.meas tran t_lo_cross when v(out)=v(lo) cross=last
.meas tran t_hi_cross when v(out)=v(hi) cross=last
.control
save all
alter vdd=1.8
tran 1n 4e-06
quit
.endc
.end
