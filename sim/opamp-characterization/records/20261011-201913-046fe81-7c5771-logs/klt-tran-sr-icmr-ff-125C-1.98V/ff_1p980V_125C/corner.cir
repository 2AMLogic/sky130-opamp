* klt sim -- generated corner deck, do not edit
.lib /opt/pdk/sky130A/libs.tech/ngspice/sky130.lib.spice ff
.include /var/tmp/eda-job-klt-sim-9c112dab2532/inputs/netlist.cir
.temp 125.0
.meas tran vout_pre_v find v(out) at=190n
.control
alter vdd=1.98
set filetype=ascii
tran 2n 2.2u
write /var/tmp/eda-job-klt-sim-9c112dab2532/outputs/artifacts/ff_1p980V_125C/waveform.raw
quit
.endc
.end
