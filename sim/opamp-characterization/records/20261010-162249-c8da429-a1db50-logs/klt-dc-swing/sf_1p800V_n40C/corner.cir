* klt sim -- generated corner deck, do not edit
.lib /opt/pdk/sky130A/libs.tech/ngspice/sky130.lib.spice sf
.include /var/tmp/eda-job-klt-sim-874a9ad18b39/inputs/netlist.cir
.temp -40.0
.meas dc vout_mid_v find v(out) at=0.5
.control
alter vdd=1.8
set filetype=ascii
dc Vsw 0 1.000001 0.00277777777778
write /var/tmp/eda-job-klt-sim-874a9ad18b39/outputs/artifacts/sf_1p800V_n40C/waveform.raw
quit
.endc
.end
