* klt sim -- generated corner deck, do not edit
.lib /opt/pdk/sky130A/libs.tech/ngspice/sky130.lib.spice fs
.include /var/tmp/eda-job-klt-sim-8688c62b0000/inputs/netlist.cir
.temp 27.0
.meas tran v_init find v(out) at=1.9e-07
.meas tran v_ofs find v(ofs) at=1.9e-07
.meas tran v_final find v(out) at=4e-06
.meas tran v_peak max v(out) from=2e-07 to=4e-06
.meas tran t_lo_cross when v(out)=v(lo) cross=last
.meas tran t_hi_cross when v(out)=v(hi) cross=last
.control
alter vdd=1.8
tran 1n 4e-06
quit
.endc
.end
