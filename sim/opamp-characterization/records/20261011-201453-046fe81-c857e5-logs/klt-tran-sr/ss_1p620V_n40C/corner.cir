* klt sim -- generated corner deck, do not edit
.lib /home/ubuntu/.volare/sky130A/libs.tech/ngspice/sky130.lib.spice ss
.include /tmp/opamp-klt-9ewqtskt/tran-sr-body.spice
.temp -40.0
.meas tran t20_rise when v(out)=v(l20) rise=1
.meas tran t80_rise when v(out)=v(l80) rise=1
.meas tran t80_fall when v(out)=v(l80) fall=1
.meas tran t20_fall when v(out)=v(l20) fall=1
.control
save all
alter vdd=1.62
tran 2n 2.2u
quit
.endc
.end
