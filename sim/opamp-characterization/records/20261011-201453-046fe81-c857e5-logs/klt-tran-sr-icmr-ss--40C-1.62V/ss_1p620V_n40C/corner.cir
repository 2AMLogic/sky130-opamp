* klt sim -- generated corner deck, do not edit
.lib /home/ubuntu/.volare/sky130A/libs.tech/ngspice/sky130.lib.spice ss
.include /tmp/opamp-klt-sr-hip67of9/tran-sr-icmr-ss--40C-1.62V-body.spice
.temp -40.0
.meas tran vout_pre_v find v(out) at=190n
.control
save all
alter vdd=1.62
set filetype=ascii
tran 2n 2.2u
write /home/ubuntu/GitHub/sky130-opamp/.loom/worktrees/issue-185/sim/opamp-characterization/records/20261011-201453-046fe81-c857e5-logs/klt-tran-sr-icmr-ss--40C-1.62V/ss_1p620V_n40C/waveform.raw
quit
.endc
.end
