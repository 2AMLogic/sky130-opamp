* klt sim -- generated corner deck, do not edit
.lib /opt/pdk/sky130A/libs.tech/ngspice/sky130.lib.spice ss
.include /var/tmp/eda-job-klt-sim-866e54b7a0d6/inputs/netlist.cir
.temp -40.0
.meas tran vout_pre_v find v(out) at=190n
.control
alter vdd=1.62
set filetype=ascii
tran 2n 2.2u
write /var/tmp/eda-job-klt-sim-866e54b7a0d6/outputs/artifacts/ss_1p620V_n40C/waveform.raw
quit
.endc
.end
