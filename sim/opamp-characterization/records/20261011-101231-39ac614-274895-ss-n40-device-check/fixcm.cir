* SS/-40C/1.62V single-corner device-parameter check (issue #181), local ngspice -b
.lib /home/ubuntu/.volare/sky130A/libs.tech/ngspice/sky130.lib.spice ss
.include swing-fixcm-body.spice
.temp -40
.control
save all @m.xdut.xm1.msky130_fd_pr__nfet_01v8[vds] @m.xdut.xm1.msky130_fd_pr__nfet_01v8[vgs] @m.xdut.xm1.msky130_fd_pr__nfet_01v8[vth] @m.xdut.xm1.msky130_fd_pr__nfet_01v8[vdsat] @m.xdut.xm1.msky130_fd_pr__nfet_01v8[id] @m.xdut.xm2.msky130_fd_pr__nfet_01v8[vds] @m.xdut.xm2.msky130_fd_pr__nfet_01v8[vgs] @m.xdut.xm2.msky130_fd_pr__nfet_01v8[vth] @m.xdut.xm2.msky130_fd_pr__nfet_01v8[vdsat] @m.xdut.xm2.msky130_fd_pr__nfet_01v8[id] @m.xdut.xm3.msky130_fd_pr__pfet_01v8[vds] @m.xdut.xm3.msky130_fd_pr__pfet_01v8[vgs] @m.xdut.xm3.msky130_fd_pr__pfet_01v8[vth] @m.xdut.xm3.msky130_fd_pr__pfet_01v8[vdsat] @m.xdut.xm3.msky130_fd_pr__pfet_01v8[id] @m.xdut.xm4.msky130_fd_pr__pfet_01v8[vds] @m.xdut.xm4.msky130_fd_pr__pfet_01v8[vgs] @m.xdut.xm4.msky130_fd_pr__pfet_01v8[vth] @m.xdut.xm4.msky130_fd_pr__pfet_01v8[vdsat] @m.xdut.xm4.msky130_fd_pr__pfet_01v8[id] @m.xdut.xm5.msky130_fd_pr__nfet_01v8[vds] @m.xdut.xm5.msky130_fd_pr__nfet_01v8[vgs] @m.xdut.xm5.msky130_fd_pr__nfet_01v8[vth] @m.xdut.xm5.msky130_fd_pr__nfet_01v8[vdsat] @m.xdut.xm5.msky130_fd_pr__nfet_01v8[id] @m.xdut.xm6.msky130_fd_pr__pfet_01v8[vds] @m.xdut.xm6.msky130_fd_pr__pfet_01v8[vgs] @m.xdut.xm6.msky130_fd_pr__pfet_01v8[vth] @m.xdut.xm6.msky130_fd_pr__pfet_01v8[vdsat] @m.xdut.xm6.msky130_fd_pr__pfet_01v8[id] @m.xdut.xm7.msky130_fd_pr__nfet_01v8[vds] @m.xdut.xm7.msky130_fd_pr__nfet_01v8[vgs] @m.xdut.xm7.msky130_fd_pr__nfet_01v8[vth] @m.xdut.xm7.msky130_fd_pr__nfet_01v8[vdsat] @m.xdut.xm7.msky130_fd_pr__nfet_01v8[id]
alter vdd=1.62
dc Vsw 0 1.000001 0.00277777777778
wrdata fixcm.dat v(sw) v(out) v(inp) v(inn) v(xdut.d1) v(xdut.d2) v(xdut.tail) @m.xdut.xm1.msky130_fd_pr__nfet_01v8[vds] @m.xdut.xm1.msky130_fd_pr__nfet_01v8[vgs] @m.xdut.xm1.msky130_fd_pr__nfet_01v8[vth] @m.xdut.xm1.msky130_fd_pr__nfet_01v8[vdsat] @m.xdut.xm1.msky130_fd_pr__nfet_01v8[id] @m.xdut.xm2.msky130_fd_pr__nfet_01v8[vds] @m.xdut.xm2.msky130_fd_pr__nfet_01v8[vgs] @m.xdut.xm2.msky130_fd_pr__nfet_01v8[vth] @m.xdut.xm2.msky130_fd_pr__nfet_01v8[vdsat] @m.xdut.xm2.msky130_fd_pr__nfet_01v8[id] @m.xdut.xm3.msky130_fd_pr__pfet_01v8[vds] @m.xdut.xm3.msky130_fd_pr__pfet_01v8[vgs] @m.xdut.xm3.msky130_fd_pr__pfet_01v8[vth] @m.xdut.xm3.msky130_fd_pr__pfet_01v8[vdsat] @m.xdut.xm3.msky130_fd_pr__pfet_01v8[id] @m.xdut.xm4.msky130_fd_pr__pfet_01v8[vds] @m.xdut.xm4.msky130_fd_pr__pfet_01v8[vgs] @m.xdut.xm4.msky130_fd_pr__pfet_01v8[vth] @m.xdut.xm4.msky130_fd_pr__pfet_01v8[vdsat] @m.xdut.xm4.msky130_fd_pr__pfet_01v8[id] @m.xdut.xm5.msky130_fd_pr__nfet_01v8[vds] @m.xdut.xm5.msky130_fd_pr__nfet_01v8[vgs] @m.xdut.xm5.msky130_fd_pr__nfet_01v8[vth] @m.xdut.xm5.msky130_fd_pr__nfet_01v8[vdsat] @m.xdut.xm5.msky130_fd_pr__nfet_01v8[id] @m.xdut.xm6.msky130_fd_pr__pfet_01v8[vds] @m.xdut.xm6.msky130_fd_pr__pfet_01v8[vgs] @m.xdut.xm6.msky130_fd_pr__pfet_01v8[vth] @m.xdut.xm6.msky130_fd_pr__pfet_01v8[vdsat] @m.xdut.xm6.msky130_fd_pr__pfet_01v8[id] @m.xdut.xm7.msky130_fd_pr__nfet_01v8[vds] @m.xdut.xm7.msky130_fd_pr__nfet_01v8[vgs] @m.xdut.xm7.msky130_fd_pr__nfet_01v8[vth] @m.xdut.xm7.msky130_fd_pr__nfet_01v8[vdsat] @m.xdut.xm7.msky130_fd_pr__nfet_01v8[id]
quit
.endc
.end
