* extracted by klt extract --deck sky130

* cell opamp_core
* pin ibias
* pin inn
* pin inp
* pin out
* pin vdd
* pin vss
.SUBCKT opamp_core ibias inn inp out vdd vss
* device instance $1 r0 *1 31.02,-26.09 nfet
X$1 out ibias vss vss sky130_fd_pr__nfet_01v8 L=1.2 W=7.82 AS=3.2844 AD=3.2844
+ PS=16.48 PD=16.48
* device instance $2 r0 *1 33.46,-26.09 nfet
X$2 out ibias vss vss sky130_fd_pr__nfet_01v8 L=1.2 W=7.82 AS=3.2844 AD=3.2844
+ PS=16.48 PD=16.48
* device instance $3 r0 *1 35.9,-26.09 nfet
X$3 out ibias vss vss sky130_fd_pr__nfet_01v8 L=1.2 W=7.82 AS=3.2844 AD=3.2844
+ PS=16.48 PD=16.48
* device instance $4 r0 *1 38.34,-26.09 nfet
X$4 out ibias vss vss sky130_fd_pr__nfet_01v8 L=1.2 W=7.82 AS=3.2844 AD=3.2844
+ PS=16.48 PD=16.48
* device instance $5 r0 *1 40.78,-26.09 nfet
X$5 out ibias vss vss sky130_fd_pr__nfet_01v8 L=1.2 W=7.82 AS=3.2844 AD=3.2844
+ PS=16.48 PD=16.48
* device instance $6 r0 *1 43.22,-26.09 nfet
X$6 out ibias vss vss sky130_fd_pr__nfet_01v8 L=1.2 W=7.82 AS=3.2844 AD=3.2844
+ PS=16.48 PD=16.48
* device instance $7 r0 *1 45.66,-26.09 nfet
X$7 out ibias vss vss sky130_fd_pr__nfet_01v8 L=1.2 W=7.82 AS=3.2844 AD=3.2844
+ PS=16.48 PD=16.48
* device instance $8 r0 *1 48.1,-26.09 nfet
X$8 out ibias vss vss sky130_fd_pr__nfet_01v8 L=1.2 W=7.82 AS=3.2844 AD=3.2844
+ PS=16.48 PD=16.48
* device instance $9 r0 *1 50.54,-26.09 nfet
X$9 out ibias vss vss sky130_fd_pr__nfet_01v8 L=1.2 W=7.82 AS=3.2844 AD=3.2844
+ PS=16.48 PD=16.48
* device instance $10 r0 *1 52.98,-26.09 nfet
X$10 out ibias vss vss sky130_fd_pr__nfet_01v8 L=1.2 W=7.82 AS=3.2844 AD=3.2844
+ PS=16.48 PD=16.48
* device instance $11 r0 *1 41.02,1.507 nfet
X$11 d1 inn tail vss sky130_fd_pr__nfet_01v8 L=1.2 W=3.015 AS=1.2663 AD=1.2663
+ PS=6.87 PD=6.87
* device instance $12 r0 *1 43.46,1.507 nfet
X$12 d2 inp tail vss sky130_fd_pr__nfet_01v8 L=1.2 W=3.015 AS=1.2663 AD=1.2663
+ PS=6.87 PD=6.87
* device instance $13 r0 *1 41.02,5.742 nfet
X$13 d2 inp tail vss sky130_fd_pr__nfet_01v8 L=1.2 W=3.015 AS=1.2663 AD=1.2663
+ PS=6.87 PD=6.87
* device instance $14 r0 *1 43.46,5.742 nfet
X$14 d1 inn tail vss sky130_fd_pr__nfet_01v8 L=1.2 W=3.015 AS=1.2663 AD=1.2663
+ PS=6.87 PD=6.87
* device instance $15 r0 *1 1.02,3.91 nfet
X$15 tail ibias vss vss sky130_fd_pr__nfet_01v8 L=1.2 W=7.82 AS=3.2844
+ AD=3.2844 PS=16.48 PD=16.48
* device instance $16 r0 *1 3.46,3.91 nfet
X$16 ibias ibias vss vss sky130_fd_pr__nfet_01v8 L=1.2 W=7.82 AS=3.2844
+ AD=3.2844 PS=16.48 PD=16.48
* device instance $17 r0 *1 5.9,3.91 nfet
X$17 tail ibias vss vss sky130_fd_pr__nfet_01v8 L=1.2 W=7.82 AS=3.2844
+ AD=3.2844 PS=16.48 PD=16.48
* device instance $18 r0 *1 63.57,-27.683 pfet
X$18 out d2 vdd vdd sky130_fd_pr__pfet_01v8 L=0.3 W=4.635 AS=1.9467 AD=1.9467
+ PS=10.11 PD=10.11
* device instance $19 r0 *1 65.11,-27.683 pfet
X$19 out d2 vdd vdd sky130_fd_pr__pfet_01v8 L=0.3 W=4.635 AS=1.9467 AD=1.9467
+ PS=10.11 PD=10.11
* device instance $20 r0 *1 66.65,-27.683 pfet
X$20 out d2 vdd vdd sky130_fd_pr__pfet_01v8 L=0.3 W=4.635 AS=1.9467 AD=1.9467
+ PS=10.11 PD=10.11
* device instance $21 r0 *1 68.19,-27.683 pfet
X$21 out d2 vdd vdd sky130_fd_pr__pfet_01v8 L=0.3 W=4.635 AS=1.9467 AD=1.9467
+ PS=10.11 PD=10.11
* device instance $22 r0 *1 69.73,-27.683 pfet
X$22 out d2 vdd vdd sky130_fd_pr__pfet_01v8 L=0.3 W=4.635 AS=1.9467 AD=1.9467
+ PS=10.11 PD=10.11
* device instance $23 r0 *1 71.27,-27.683 pfet
X$23 out d2 vdd vdd sky130_fd_pr__pfet_01v8 L=0.3 W=4.635 AS=1.9467 AD=1.9467
+ PS=10.11 PD=10.11
* device instance $24 r0 *1 72.81,-27.683 pfet
X$24 out d2 vdd vdd sky130_fd_pr__pfet_01v8 L=0.3 W=4.635 AS=1.9467 AD=1.9467
+ PS=10.11 PD=10.11
* device instance $25 r0 *1 74.35,-27.683 pfet
X$25 out d2 vdd vdd sky130_fd_pr__pfet_01v8 L=0.3 W=4.635 AS=1.9467 AD=1.9467
+ PS=10.11 PD=10.11
* device instance $26 r0 *1 75.89,-27.683 pfet
X$26 out d2 vdd vdd sky130_fd_pr__pfet_01v8 L=0.3 W=4.635 AS=1.9467 AD=1.9467
+ PS=10.11 PD=10.11
* device instance $27 r0 *1 77.43,-27.683 pfet
X$27 out d2 vdd vdd sky130_fd_pr__pfet_01v8 L=0.3 W=4.635 AS=1.9467 AD=1.9467
+ PS=10.11 PD=10.11
* device instance $28 r0 *1 54.57,0.772 pfet
X$28 d1 d1 vdd vdd sky130_fd_pr__pfet_01v8 L=0.3 W=1.545 AS=0.6489 AD=0.6489
+ PS=3.93 PD=3.93
* device instance $29 r0 *1 56.11,0.772 pfet
X$29 d2 d1 vdd vdd sky130_fd_pr__pfet_01v8 L=0.3 W=1.545 AS=0.6489 AD=0.6489
+ PS=3.93 PD=3.93
* device instance $30 r0 *1 57.65,0.772 pfet
X$30 d1 d1 vdd vdd sky130_fd_pr__pfet_01v8 L=0.3 W=1.545 AS=0.6489 AD=0.6489
+ PS=3.93 PD=3.93
* device instance $31 r0 *1 54.57,3.537 pfet
X$31 d2 d1 vdd vdd sky130_fd_pr__pfet_01v8 L=0.3 W=1.545 AS=0.6489 AD=0.6489
+ PS=3.93 PD=3.93
* device instance $32 r0 *1 56.11,3.537 pfet
X$32 d1 d1 vdd vdd sky130_fd_pr__pfet_01v8 L=0.3 W=1.545 AS=0.6489 AD=0.6489
+ PS=3.93 PD=3.93
* device instance $33 r0 *1 57.65,3.537 pfet
X$33 d2 d1 vdd vdd sky130_fd_pr__pfet_01v8 L=0.3 W=1.545 AS=0.6489 AD=0.6489
+ PS=3.93 PD=3.93
* device instance $34 r0 *1 103.31,-21.69 sky130_fd_pr__model__cap_mim
X$34 out cz sky130_fd_pr__cap_mim_m3_1 l=15.62 w=15.62
* device instance $35 r0 *1 102.307,-7.295 res_high_po
X$35 d2 cz vss sky130_fd_pr__res_high_po l=9.765 w=1.41
.ENDS opamp_core
