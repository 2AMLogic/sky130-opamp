* klt sim -- generated corner deck, do not edit
.lib /opt/pdk/sky130A/libs.tech/ngspice/sky130.lib.spice ss
.include /var/tmp/eda-job-klt-sim-5a7c2e13cf3d/inputs/netlist.cir
.temp 125.0
.meas dc i_vdd_a find i(vdd) at=0
.control
alter vdd=1.62
dc Vinp 0 1m 1m
quit
.endc
.end
