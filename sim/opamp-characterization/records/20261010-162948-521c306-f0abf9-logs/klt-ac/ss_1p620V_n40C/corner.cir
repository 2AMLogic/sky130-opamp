* klt sim -- generated corner deck, do not edit
.lib /opt/pdk/sky130A/libs.tech/ngspice/sky130.lib.spice ss
.include /var/tmp/eda-job-klt-sim-2bad54795afe/inputs/netlist.cir
.temp -40.0
.meas ac gain_dc_db find vdb(out) at=1
.meas ac gbw_hz when vdb(out)=0 cross=1
.meas ac phase_at_gbw_rad find vp(out) when vdb(out)=0 cross=1
.control
alter vdd=1.62
ac dec 20 1 1g
quit
.endc
.end
