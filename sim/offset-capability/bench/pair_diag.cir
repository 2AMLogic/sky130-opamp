* Device-pair mismatch diagnostic (issue #52).
* Two nominally identical nfet_01v8 and two identical pfet_01v8, each pair at
* identical bias. Under tt_mm (mc_mm_switch=1) every instance draws its own
* AGAUSS parameters, so the drain-current difference within a pair is nonzero
* and changes with the seed; under tt (mc_mm_switch=0) it must sit at the
* numerical floor. W/L are small on purpose (large sigma, easy to resolve);
* .option scale=1u matches design/netlist/opamp_core.spice.
.option scale=1u
Vdd vdd 0 dc 1.8
Vg  g   0 dc 0.8
Vgp gp  0 dc 1.0
Vn1 d1  0 dc 0.9
Vn2 d2  0 dc 0.9
Vp1 dp1 0 dc 0.9
Vp2 dp2 0 dc 0.9
XN1 d1  g  0   0   sky130_fd_pr__nfet_01v8 L=0.5 W=1 nf=1 mult=1 m=1
XN2 d2  g  0   0   sky130_fd_pr__nfet_01v8 L=0.5 W=1 nf=1 mult=1 m=1
XP1 dp1 gp vdd vdd sky130_fd_pr__pfet_01v8 L=0.5 W=1 nf=1 mult=1 m=1
XP2 dp2 gp vdd vdd sky130_fd_pr__pfet_01v8 L=0.5 W=1 nf=1 mult=1 m=1
