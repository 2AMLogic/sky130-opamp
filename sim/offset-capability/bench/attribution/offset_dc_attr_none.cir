* GENERATED by bin/attribution.py gen (issue #107) -- do not edit by hand.
* Offset bench with mismatch enabled only on: none (control: every device wrapped).
* Everything else (sources, load, sweep) is bench/offset_dc.cir verbatim; the
* netlist below is design/netlist/opamp_core.spice with every other device
* routed through the mmoff_* wrappers.
* Open-loop input-referred offset probe (issue #52).
* vd = V(inp) - V(inn), swept DC; V(inn) = VCM fixed. Vos is the vd at which
* v(out) crosses VREF = VDD/2 (rising crossing; the amplifier is
* non-inverting from inp, so out rises with vd). Systematic + random offset
* are both included; nothing is subtracted.
* Same supply/bias/load conventions as the PSRR/noise benches
* (../../opamp-characterization/testbench/psrr_vdd.cir): VDD 1.8 V, ideal
* 5 uA Iref, 2 pF Cload, no bias generator. VCM = 0.9 V (VDD/2, the PSRR
* benches' input common mode).
* Template: offset_probe.py renders this per campaign into records/dut-<label>/
* offset_dc.spice, with the include below rewritten to the captured DUT copy
* (issue #113). Run directly, it uses the live design netlist.
.option scale=1u
* mismatch-off wrappers (issue #107). The local `.param mc_mm_switch=0` shadows
* the library's global switch for everything instantiated inside, so the PDK
* device keeps its nominal (non-random) model while the rest of the deck, and
* the library section, still have mismatch on. Parameter lists mirror the PDK
* subcircuits; `mult` and `m` are passed to the inner device explicitly. (Without the
* explicit `m`, ngspice dropped the X-line multiplier when no un-wrapped device of
* that kind was left in the deck: a 1-2 mV systematic shift, caught by the control.)
.subckt mmoff_nfet d g s b l=1 w=1 nf=1 ad=0 as=0 pd=0 ps=0 nrd=0 nrs=0 sa=0 sb=0 sd=0 mult=1 m=1
.param mc_mm_switch=0
XX d g s b sky130_fd_pr__nfet_01v8 l={l} w={w} nf={nf} ad={ad} as={as} pd={pd} ps={ps} nrd={nrd} nrs={nrs} sa={sa} sb={sb} sd={sd} mult={mult} m={m}
.ends
.subckt mmoff_pfet d g s b l=1 w=1 nf=1 ad=0 as=0 pd=0 ps=0 nrd=0 nrs=0 sa=0 sb=0 sd=0 mult=1 m=1
.param mc_mm_switch=0
XX d g s b sky130_fd_pr__pfet_01v8 l={l} w={w} nf={nf} ad={ad} as={as} pd={pd} ps={ps} nrd={nrd} nrs={nrs} sa={sa} sb={sb} sd={sd} mult={mult} m={m}
.ends
.subckt mmoff_res r0 r1 b l=5 w=1.41 mult=1 m=1
.param mc_mm_switch=0
XX r0 r1 b sky130_fd_pr__res_high_po_1p41 l={l} w={w} mult={mult} m={m}
.ends
.subckt mmoff_cap c0 c1 w=1 l=1 mf=1 m=1
.param mc_mm_switch=0
XX c0 c1 sky130_fd_pr__cap_mim_m3_1 w={w} l={l} mf={mf} m={m}
.ends
* ---- opamp_core.spice (gated) ----
** sch_path: /Users/rwalters/GitHub/sky130-opamp/.loom/worktrees/issue-13/design/opamp_core.sch
**.subckt opamp_core vdd vss inn inp out ibias
*.iopin vdd
*.iopin vss
*.iopin inn
*.iopin inp
*.iopin out
*.iopin ibias
XM3 d1 d1 vdd vdd mmoff_pfet L=0.3 W=4.634 nf=1 ad=1.34386 as=1.34386 pd=9.85 ps=9.85 nrd=0.06258092360811393 nrs=0.06258092360811393 sa=0 sb=0 sd=0 mult=1 m=1
XM4 d2 d1 vdd vdd mmoff_pfet L=0.3 W=4.634 nf=1 ad=1.34386 as=1.34386 pd=9.85 ps=9.85 nrd=0.06258092360811393 nrs=0.06258092360811393 sa=0 sb=0 sd=0 mult=1 m=1
XM1 d1 inn tail vss mmoff_nfet L=1.2 W=6.03 nf=1 ad=1.7487 as=1.7487 pd=12.64 ps=12.64 nrd=0.04809286898839137 nrs=0.04809286898839137 sa=0 sb=0 sd=0 mult=1 m=1
XM2 d2 inp tail vss mmoff_nfet L=1.2 W=6.03 nf=1 ad=1.7487 as=1.7487 pd=12.64 ps=12.64 nrd=0.04809286898839137 nrs=0.04809286898839137 sa=0 sb=0 sd=0 mult=1 m=1
XM5 tail ibias vss vss mmoff_nfet L=1.2 W=7.819 nf=1 ad=2.26751 as=2.26751 pd=16.22 ps=16.22 nrd=0.037089141833994116 nrs=0.037089141833994116 sa=0 sb=0 sd=0 mult=2 m=2
XMB1 ibias ibias vss vss mmoff_nfet L=1.2 W=7.819 nf=1 ad=2.26751 as=2.26751 pd=16.22 ps=16.22 nrd=0.037089141833994116 nrs=0.037089141833994116 sa=0 sb=0 sd=0 mult=1 m=1
XM6 out d2 vdd vdd mmoff_pfet L=0.3 W=4.634 nf=1 ad=1.34386 as=1.34386 pd=9.85 ps=9.85 nrd=0.06258092360811393 nrs=0.06258092360811393 sa=0 sb=0 sd=0 mult=10 m=10
XM7 out ibias vss vss mmoff_nfet L=1.2 W=7.819 nf=1 ad=2.26751 as=2.26751 pd=16.22 ps=16.22 nrd=0.037089141833994116 nrs=0.037089141833994116 sa=0 sb=0 sd=0 mult=10 m=10
XRz cz d2 vss mmoff_res L=9.763 mult=1 m=1
XCc cz out mmoff_cap W=15.62 L=15.62 MF=1 m=1
**.ends

Vdd vdd 0 dc 1.8
Vss vss 0 dc 0
Iref vdd ibias dc 5u
Vinn inn 0 dc 0.9
Vd  inp inn dc 0
Cload out 0 2p
