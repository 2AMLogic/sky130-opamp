** CANDIDATE netlist 'm4p2' for the issue #144 sizing-feasibility study -- NOT the canonical design.
** Generated by sim/offset-capability/bin/sizing_feasibility.py gen from design/netlist/opamp_core.spice;
** largest bounded step along the area-optimal direction (mirror area factor ~ 5.7x the pair's, see `bounds`): PMOS x4 (area x16), pair x2 (area x4).
** pmos_scale=4 (XM3/XM4/XM6 W and L), pair_scale=2 (XM1/XM2 W and L);
** every W/L snapped to the 0.005 um grid; bias group W 7.819 -> 7.820 placeholder (owned by #120).
** sch_path: /Users/rwalters/GitHub/sky130-opamp/.loom/worktrees/issue-13/design/opamp_core.sch
**.subckt opamp_core vdd vss inn inp out ibias
*.iopin vdd
*.iopin vss
*.iopin inn
*.iopin inp
*.iopin out
*.iopin ibias
XM3 d1 d1 vdd vdd sky130_fd_pr__pfet_01v8 L=1.2 W=18.535 nf=1 ad=5.37515 as=5.37515 pd=37.65 ps=37.65 nrd=0.0156461 nrs=0.0156461 sa=0 sb=0 sd=0 mult=1 m=1
XM4 d2 d1 vdd vdd sky130_fd_pr__pfet_01v8 L=1.2 W=18.535 nf=1 ad=5.37515 as=5.37515 pd=37.65 ps=37.65 nrd=0.0156461 nrs=0.0156461 sa=0 sb=0 sd=0 mult=1 m=1
XM1 d1 inn tail vss sky130_fd_pr__nfet_01v8 L=2.4 W=12.06 nf=1 ad=3.4974 as=3.4974 pd=24.7 ps=24.7 nrd=0.0240464 nrs=0.0240464 sa=0 sb=0 sd=0 mult=1 m=1
XM2 d2 inp tail vss sky130_fd_pr__nfet_01v8 L=2.4 W=12.06 nf=1 ad=3.4974 as=3.4974 pd=24.7 ps=24.7 nrd=0.0240464 nrs=0.0240464 sa=0 sb=0 sd=0 mult=1 m=1
XM5 tail ibias vss vss sky130_fd_pr__nfet_01v8 L=1.2 W=7.82 nf=1 ad=2.2678 as=2.2678 pd=16.22 ps=16.22 nrd=0.0370844 nrs=0.0370844 sa=0 sb=0 sd=0 mult=2 m=2
XMB1 ibias ibias vss vss sky130_fd_pr__nfet_01v8 L=1.2 W=7.82 nf=1 ad=2.2678 as=2.2678 pd=16.22 ps=16.22 nrd=0.0370844 nrs=0.0370844 sa=0 sb=0 sd=0 mult=1 m=1
XM6 out d2 vdd vdd sky130_fd_pr__pfet_01v8 L=1.2 W=18.535 nf=1 ad=5.37515 as=5.37515 pd=37.65 ps=37.65 nrd=0.0156461 nrs=0.0156461 sa=0 sb=0 sd=0 mult=10 m=10
XM7 out ibias vss vss sky130_fd_pr__nfet_01v8 L=1.2 W=7.82 nf=1 ad=2.2678 as=2.2678 pd=16.22 ps=16.22 nrd=0.0370844 nrs=0.0370844 sa=0 sb=0 sd=0 mult=10 m=10
XRz cz d2 vss sky130_fd_pr__res_high_po_1p41 L=9.765 mult=1 m=1
XCc cz out sky130_fd_pr__cap_mim_m3_1 W=15.62 L=15.62 MF=1 m=1
**.ends
.end
