* LVS reference for opamp_bias -- GENERATED by layout/bin/stage_reference.py
* Source: design/netlist/opamp_core.spice, device cards XMB1, XM5
* Cards copied verbatim (continuations joined); do not hand-edit.
* Exception: a MOS card with m=N is written as N cards <name>_1.._N with
* m=1 mult=1, because klt lvs cannot represent m>1 (see expand_multiplicity).
.subckt opamp_bias ibias tail vss
XMB1 ibias ibias vss vss sky130_fd_pr__nfet_01v8 L=1.2 W=7.820 nf=1 ad=2.2678 as=2.2678 pd=16.22 ps=16.22 nrd=0.0370843989769821 nrs=0.0370843989769821 sa=0 sb=0 sd=0 mult=1 m=1
XM5_1 tail ibias vss vss sky130_fd_pr__nfet_01v8 L=1.2 W=7.820 nf=1 ad=2.2678 as=2.2678 pd=16.22 ps=16.22 nrd=0.0370843989769821 nrs=0.0370843989769821 sa=0 sb=0 sd=0 mult=1 m=1
XM5_2 tail ibias vss vss sky130_fd_pr__nfet_01v8 L=1.2 W=7.820 nf=1 ad=2.2678 as=2.2678 pd=16.22 ps=16.22 nrd=0.0370843989769821 nrs=0.0370843989769821 sa=0 sb=0 sd=0 mult=1 m=1
.ends opamp_bias
.end
