* extracted by klt extract --deck sky130

* cell opamp_bias
* pin ibias
* pin tail
* pin vss
.SUBCKT opamp_bias ibias tail vss
* device instance $1 r0 *1 1.02,3.91 nfet
M$1 tail ibias vss vss nfet L=1.2U W=7.82U AS=3.2844P AD=3.2844P PS=16.48U
+ PD=16.48U
* device instance $2 r0 *1 3.46,3.91 nfet
M$2 ibias ibias vss vss nfet L=1.2U W=7.82U AS=3.2844P AD=3.2844P PS=16.48U
+ PD=16.48U
* device instance $3 r0 *1 5.9,3.91 nfet
M$3 tail ibias vss vss nfet L=1.2U W=7.82U AS=3.2844P AD=3.2844P PS=16.48U
+ PD=16.48U
.ENDS opamp_bias
