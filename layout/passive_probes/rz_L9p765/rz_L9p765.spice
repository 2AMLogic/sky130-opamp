* extracted by klt extract --deck sky130

* cell rz_L9p765
* pin vsubs
.SUBCKT rz_L9p765 vsubs
* device instance $1 r0 *1 5.302,0.705 res_high_po
X$1 \$1 \$2 vsubs res_high_po r=2629.30659215 L=9.765U W=1.41U
.ENDS rz_L9p765
