* extracted by klt extract --deck sky130

* cell cc_15p62
.SUBCKT cc_15p62
* device instance $1 r0 *1 8.31,8.31 sky130_fd_pr__model__cap_mim
C$1 \$1 \$2 4.9984e-13
.ENDS cc_15p62
