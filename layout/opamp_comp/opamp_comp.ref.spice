* LVS reference for opamp_comp -- GENERATED by layout/bin/stage_reference.py
* Source: design/netlist/opamp_core.spice, device cards XRz, XCc
* Cards copied verbatim (continuations joined); do not hand-edit.
.subckt opamp_comp d2 out cz vss
XRz cz d2 vss sky130_fd_pr__res_high_po_1p41 L=9.765 mult=1 m=1
XCc cz out sky130_fd_pr__cap_mim_m3_1 W=15.62 L=15.62 MF=1 m=1
.ends opamp_comp
.end
