* extracted by klt extract --deck sky130

* cell opamp_stage1
* pin d1
* pin d2
* pin inn
* pin inp
* pin tail
* pin vdd
* pin vss
.SUBCKT opamp_stage1 d1 d2 inn inp tail vdd vss
* device instance $1 r0 *1 1.02,1.507 nfet
M$1 d1 inn tail vss nfet L=1.2U W=3.015U AS=1.2663P AD=1.2663P PS=6.87U PD=6.87U
* device instance $2 r0 *1 3.46,1.507 nfet
M$2 d2 inp tail vss nfet L=1.2U W=3.015U AS=1.2663P AD=1.2663P PS=6.87U PD=6.87U
* device instance $3 r0 *1 1.02,5.742 nfet
M$3 d2 inp tail vss nfet L=1.2U W=3.015U AS=1.2663P AD=1.2663P PS=6.87U PD=6.87U
* device instance $4 r0 *1 3.46,5.742 nfet
M$4 d1 inn tail vss nfet L=1.2U W=3.015U AS=1.2663P AD=1.2663P PS=6.87U PD=6.87U
* device instance $5 r0 *1 14.57,0.772 pfet
M$5 d1 d1 vdd vdd pfet L=0.3U W=1.545U AS=0.6489P AD=0.6489P PS=3.93U PD=3.93U
* device instance $6 r0 *1 16.11,0.772 pfet
M$6 d2 d1 vdd vdd pfet L=0.3U W=1.545U AS=0.6489P AD=0.6489P PS=3.93U PD=3.93U
* device instance $7 r0 *1 17.65,0.772 pfet
M$7 d1 d1 vdd vdd pfet L=0.3U W=1.545U AS=0.6489P AD=0.6489P PS=3.93U PD=3.93U
* device instance $8 r0 *1 14.57,3.537 pfet
M$8 d2 d1 vdd vdd pfet L=0.3U W=1.545U AS=0.6489P AD=0.6489P PS=3.93U PD=3.93U
* device instance $9 r0 *1 16.11,3.537 pfet
M$9 d1 d1 vdd vdd pfet L=0.3U W=1.545U AS=0.6489P AD=0.6489P PS=3.93U PD=3.93U
* device instance $10 r0 *1 17.65,3.537 pfet
M$10 d2 d1 vdd vdd pfet L=0.3U W=1.545U AS=0.6489P AD=0.6489P PS=3.93U PD=3.93U
.ENDS opamp_stage1
