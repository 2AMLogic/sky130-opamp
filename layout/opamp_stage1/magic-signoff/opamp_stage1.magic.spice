* NGSPICE file created from opamp_stage1.ext - technology: sky130A

.subckt opamp_stage1 tail vdd d1 inn d2 inp vss
X0 d1 d1 vdd vdd sky130_fd_pr__pfet_01v8 ad=0.6489 pd=3.93 as=0.6489 ps=3.93 w=1.545 l=0.3
X1 d2 d1 vdd vdd sky130_fd_pr__pfet_01v8 ad=0.6489 pd=3.93 as=0.6489 ps=3.93 w=1.545 l=0.3
X2 d2 inp tail vss sky130_fd_pr__nfet_01v8 ad=1.2663 pd=6.87 as=1.2663 ps=6.87 w=3.015 l=1.2
X3 d2 inp tail vss sky130_fd_pr__nfet_01v8 ad=1.2663 pd=6.87 as=1.2663 ps=6.87 w=3.015 l=1.2
X4 d1 inn tail vss sky130_fd_pr__nfet_01v8 ad=1.2663 pd=6.87 as=1.2663 ps=6.87 w=3.015 l=1.2
X5 d1 d1 vdd vdd sky130_fd_pr__pfet_01v8 ad=0.6489 pd=3.93 as=0.6489 ps=3.93 w=1.545 l=0.3
X6 d2 d1 vdd vdd sky130_fd_pr__pfet_01v8 ad=0.6489 pd=3.93 as=0.6489 ps=3.93 w=1.545 l=0.3
X7 d2 d1 vdd vdd sky130_fd_pr__pfet_01v8 ad=0.6489 pd=3.93 as=0.6489 ps=3.93 w=1.545 l=0.3
X8 d1 inn tail vss sky130_fd_pr__nfet_01v8 ad=1.2663 pd=6.87 as=1.2663 ps=6.87 w=3.015 l=1.2
X9 d1 d1 vdd vdd sky130_fd_pr__pfet_01v8 ad=0.6489 pd=3.93 as=0.6489 ps=3.93 w=1.545 l=0.3
.ends
