* LVS reference for opamp_stage1 -- GENERATED by layout/bin/stage_reference.py
* Source: design/netlist/opamp_core.spice, device cards XM1, XM2
* Cards copied verbatim (continuations joined); do not hand-edit.
.subckt opamp_stage1 inn inp tail d1 d2 vss
XM1 d1 inn tail vss sky130_fd_pr__nfet_01v8 L=1.2 W=6.03 nf=1 ad=1.7487 as=1.7487 pd=12.64 ps=12.64 nrd=0.04809286898839137 nrs=0.04809286898839137 sa=0 sb=0 sd=0 mult=1 m=1
XM2 d2 inp tail vss sky130_fd_pr__nfet_01v8 L=1.2 W=6.03 nf=1 ad=1.7487 as=1.7487 pd=12.64 ps=12.64 nrd=0.04809286898839137 nrs=0.04809286898839137 sa=0 sb=0 sd=0 mult=1 m=1
.ends opamp_stage1
.end
