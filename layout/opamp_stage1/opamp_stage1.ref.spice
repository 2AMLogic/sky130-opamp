* LVS reference for opamp_stage1 -- GENERATED by layout/bin/stage_reference.py
* Source: design/netlist/opamp_core.spice, device cards XM1, XM2, XM3, XM4
* Cards copied verbatim (continuations joined); do not hand-edit.
.subckt opamp_stage1 inn inp tail d1 d2 vdd vss
XM1 d1 inn tail vss sky130_fd_pr__nfet_01v8 L=1.2 W=6.030 nf=1 ad=1.7487 as=1.7487 pd=12.64 ps=12.64 nrd=0.0480928689883914 nrs=0.0480928689883914 sa=0 sb=0 sd=0 mult=1 m=1
XM2 d2 inp tail vss sky130_fd_pr__nfet_01v8 L=1.2 W=6.030 nf=1 ad=1.7487 as=1.7487 pd=12.64 ps=12.64 nrd=0.0480928689883914 nrs=0.0480928689883914 sa=0 sb=0 sd=0 mult=1 m=1
XM3 d1 d1 vdd vdd sky130_fd_pr__pfet_01v8 L=0.3 W=4.635 nf=1 ad=1.34415 as=1.34415 pd=9.85 ps=9.85 nrd=0.0625674217907228 nrs=0.0625674217907228 sa=0 sb=0 sd=0 mult=1 m=1
XM4 d2 d1 vdd vdd sky130_fd_pr__pfet_01v8 L=0.3 W=4.635 nf=1 ad=1.34415 as=1.34415 pd=9.85 ps=9.85 nrd=0.0625674217907228 nrs=0.0625674217907228 sa=0 sb=0 sd=0 mult=1 m=1
.ends opamp_stage1
.end
