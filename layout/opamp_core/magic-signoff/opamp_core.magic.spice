* NGSPICE file created from opamp_core.ext - technology: sky130A

.subckt opamp_core d2 inp out inn vss cz ibias tail vdd d1
X0 d2 cz vss sky130_fd_pr__res_high_po_1p41 l=9.765
X1 ibias ibias vss vss sky130_fd_pr__nfet_01v8 ad=3.2844 pd=16.48 as=3.2844 ps=16.48 w=7.82 l=1.2
X2 d1 inn tail vss sky130_fd_pr__nfet_01v8 ad=1.2663 pd=6.87 as=1.2663 ps=6.87 w=3.015 l=1.2
X3 d1 d1 vdd vdd sky130_fd_pr__pfet_01v8 ad=0.6489 pd=3.93 as=0.6489 ps=3.93 w=1.545 l=0.3
X4 out ibias vss vss sky130_fd_pr__nfet_01v8 ad=3.2844 pd=16.48 as=3.2844 ps=16.48 w=7.82 l=1.2
X5 out d2 vdd vdd sky130_fd_pr__pfet_01v8 ad=1.9467 pd=10.11 as=1.9467 ps=10.11 w=4.635 l=0.3
X6 out ibias vss vss sky130_fd_pr__nfet_01v8 ad=3.2844 pd=16.48 as=3.2844 ps=16.48 w=7.82 l=1.2
X7 out ibias vss vss sky130_fd_pr__nfet_01v8 ad=3.2844 pd=16.48 as=3.2844 ps=16.48 w=7.82 l=1.2
X8 d1 inn tail vss sky130_fd_pr__nfet_01v8 ad=1.2663 pd=6.87 as=1.2663 ps=6.87 w=3.015 l=1.2
X9 out d2 vdd vdd sky130_fd_pr__pfet_01v8 ad=1.9467 pd=10.11 as=1.9467 ps=10.11 w=4.635 l=0.3
X10 tail ibias vss vss sky130_fd_pr__nfet_01v8 ad=3.2844 pd=16.48 as=3.2844 ps=16.48 w=7.82 l=1.2
X11 out ibias vss vss sky130_fd_pr__nfet_01v8 ad=3.2844 pd=16.48 as=3.2844 ps=16.48 w=7.82 l=1.2
X12 out ibias vss vss sky130_fd_pr__nfet_01v8 ad=3.2844 pd=16.48 as=3.2844 ps=16.48 w=7.82 l=1.2
X13 out ibias vss vss sky130_fd_pr__nfet_01v8 ad=3.2844 pd=16.48 as=3.2844 ps=16.48 w=7.82 l=1.2
X14 d1 d1 vdd vdd sky130_fd_pr__pfet_01v8 ad=0.6489 pd=3.93 as=0.6489 ps=3.93 w=1.545 l=0.3
X15 out d2 vdd vdd sky130_fd_pr__pfet_01v8 ad=1.9467 pd=10.11 as=1.9467 ps=10.11 w=4.635 l=0.3
X16 out d2 vdd vdd sky130_fd_pr__pfet_01v8 ad=1.9467 pd=10.11 as=1.9467 ps=10.11 w=4.635 l=0.3
X17 out d2 vdd vdd sky130_fd_pr__pfet_01v8 ad=1.9467 pd=10.11 as=1.9467 ps=10.11 w=4.635 l=0.3
X18 d2 inp tail vss sky130_fd_pr__nfet_01v8 ad=1.2663 pd=6.87 as=1.2663 ps=6.87 w=3.015 l=1.2
X19 out d2 vdd vdd sky130_fd_pr__pfet_01v8 ad=1.9467 pd=10.11 as=1.9467 ps=10.11 w=4.635 l=0.3
X20 d2 inp tail vss sky130_fd_pr__nfet_01v8 ad=1.2663 pd=6.87 as=1.2663 ps=6.87 w=3.015 l=1.2
X21 out ibias vss vss sky130_fd_pr__nfet_01v8 ad=3.2844 pd=16.48 as=3.2844 ps=16.48 w=7.82 l=1.2
X22 out d2 vdd vdd sky130_fd_pr__pfet_01v8 ad=1.9467 pd=10.11 as=1.9467 ps=10.11 w=4.635 l=0.3
X23 out ibias vss vss sky130_fd_pr__nfet_01v8 ad=3.2844 pd=16.48 as=3.2844 ps=16.48 w=7.82 l=1.2
X24 d2 d1 vdd vdd sky130_fd_pr__pfet_01v8 ad=0.6489 pd=3.93 as=0.6489 ps=3.93 w=1.545 l=0.3
X25 d2 d1 vdd vdd sky130_fd_pr__pfet_01v8 ad=0.6489 pd=3.93 as=0.6489 ps=3.93 w=1.545 l=0.3
X26 d1 d1 vdd vdd sky130_fd_pr__pfet_01v8 ad=0.6489 pd=3.93 as=0.6489 ps=3.93 w=1.545 l=0.3
X27 out d2 vdd vdd sky130_fd_pr__pfet_01v8 ad=1.9467 pd=10.11 as=1.9467 ps=10.11 w=4.635 l=0.3
X28 d2 d1 vdd vdd sky130_fd_pr__pfet_01v8 ad=0.6489 pd=3.93 as=0.6489 ps=3.93 w=1.545 l=0.3
X29 out ibias vss vss sky130_fd_pr__nfet_01v8 ad=3.2844 pd=16.48 as=3.2844 ps=16.48 w=7.82 l=1.2
X30 out ibias vss vss sky130_fd_pr__nfet_01v8 ad=3.2844 pd=16.48 as=3.2844 ps=16.48 w=7.82 l=1.2
X31 out d2 vdd vdd sky130_fd_pr__pfet_01v8 ad=1.9467 pd=10.11 as=1.9467 ps=10.11 w=4.635 l=0.3
X32 tail ibias vss vss sky130_fd_pr__nfet_01v8 ad=3.2844 pd=16.48 as=3.2844 ps=16.48 w=7.82 l=1.2
X33 out d2 vdd vdd sky130_fd_pr__pfet_01v8 ad=1.9467 pd=10.11 as=1.9467 ps=10.11 w=4.635 l=0.3
X34 cz out sky130_fd_pr__cap_mim_m3_1 l=15.62 w=15.62
.ends
