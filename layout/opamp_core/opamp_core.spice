* extracted by klt extract --deck sky130

* cell opamp_core
* pin cz
* pin d1
* pin d2
* pin ibias
* pin inn
* pin inp
* pin out
* pin tail
* pin vdd
* pin vss
.SUBCKT opamp_core cz d1 d2 ibias inn inp out tail vdd vss
* device instance $1 r0 *1 31.02,-26.09 nfet
M$1 out ibias vss vss nfet L=1.2U W=7.82U AS=3.2844P AD=3.2844P PS=16.48U
+ PD=16.48U
* device instance $2 r0 *1 33.46,-26.09 nfet
M$2 out ibias vss vss nfet L=1.2U W=7.82U AS=3.2844P AD=3.2844P PS=16.48U
+ PD=16.48U
* device instance $3 r0 *1 35.9,-26.09 nfet
M$3 out ibias vss vss nfet L=1.2U W=7.82U AS=3.2844P AD=3.2844P PS=16.48U
+ PD=16.48U
* device instance $4 r0 *1 38.34,-26.09 nfet
M$4 out ibias vss vss nfet L=1.2U W=7.82U AS=3.2844P AD=3.2844P PS=16.48U
+ PD=16.48U
* device instance $5 r0 *1 40.78,-26.09 nfet
M$5 out ibias vss vss nfet L=1.2U W=7.82U AS=3.2844P AD=3.2844P PS=16.48U
+ PD=16.48U
* device instance $6 r0 *1 43.22,-26.09 nfet
M$6 out ibias vss vss nfet L=1.2U W=7.82U AS=3.2844P AD=3.2844P PS=16.48U
+ PD=16.48U
* device instance $7 r0 *1 45.66,-26.09 nfet
M$7 out ibias vss vss nfet L=1.2U W=7.82U AS=3.2844P AD=3.2844P PS=16.48U
+ PD=16.48U
* device instance $8 r0 *1 48.1,-26.09 nfet
M$8 out ibias vss vss nfet L=1.2U W=7.82U AS=3.2844P AD=3.2844P PS=16.48U
+ PD=16.48U
* device instance $9 r0 *1 50.54,-26.09 nfet
M$9 out ibias vss vss nfet L=1.2U W=7.82U AS=3.2844P AD=3.2844P PS=16.48U
+ PD=16.48U
* device instance $10 r0 *1 52.98,-26.09 nfet
M$10 out ibias vss vss nfet L=1.2U W=7.82U AS=3.2844P AD=3.2844P PS=16.48U
+ PD=16.48U
* device instance $11 r0 *1 41.02,1.507 nfet
M$11 d1 inn tail vss nfet L=1.2U W=3.015U AS=1.2663P AD=1.2663P PS=6.87U
+ PD=6.87U
* device instance $12 r0 *1 43.46,1.507 nfet
M$12 d2 inp tail vss nfet L=1.2U W=3.015U AS=1.2663P AD=1.2663P PS=6.87U
+ PD=6.87U
* device instance $13 r0 *1 41.02,5.742 nfet
M$13 d2 inp tail vss nfet L=1.2U W=3.015U AS=1.2663P AD=1.2663P PS=6.87U
+ PD=6.87U
* device instance $14 r0 *1 43.46,5.742 nfet
M$14 d1 inn tail vss nfet L=1.2U W=3.015U AS=1.2663P AD=1.2663P PS=6.87U
+ PD=6.87U
* device instance $15 r0 *1 1.02,3.91 nfet
M$15 tail ibias vss vss nfet L=1.2U W=7.82U AS=3.2844P AD=3.2844P PS=16.48U
+ PD=16.48U
* device instance $16 r0 *1 3.46,3.91 nfet
M$16 ibias ibias vss vss nfet L=1.2U W=7.82U AS=3.2844P AD=3.2844P PS=16.48U
+ PD=16.48U
* device instance $17 r0 *1 5.9,3.91 nfet
M$17 tail ibias vss vss nfet L=1.2U W=7.82U AS=3.2844P AD=3.2844P PS=16.48U
+ PD=16.48U
* device instance $18 r0 *1 63.57,-27.683 pfet
M$18 out d2 vdd vdd pfet L=0.3U W=4.635U AS=1.9467P AD=1.9467P PS=10.11U
+ PD=10.11U
* device instance $19 r0 *1 65.11,-27.683 pfet
M$19 out d2 vdd vdd pfet L=0.3U W=4.635U AS=1.9467P AD=1.9467P PS=10.11U
+ PD=10.11U
* device instance $20 r0 *1 66.65,-27.683 pfet
M$20 out d2 vdd vdd pfet L=0.3U W=4.635U AS=1.9467P AD=1.9467P PS=10.11U
+ PD=10.11U
* device instance $21 r0 *1 68.19,-27.683 pfet
M$21 out d2 vdd vdd pfet L=0.3U W=4.635U AS=1.9467P AD=1.9467P PS=10.11U
+ PD=10.11U
* device instance $22 r0 *1 69.73,-27.683 pfet
M$22 out d2 vdd vdd pfet L=0.3U W=4.635U AS=1.9467P AD=1.9467P PS=10.11U
+ PD=10.11U
* device instance $23 r0 *1 71.27,-27.683 pfet
M$23 out d2 vdd vdd pfet L=0.3U W=4.635U AS=1.9467P AD=1.9467P PS=10.11U
+ PD=10.11U
* device instance $24 r0 *1 72.81,-27.683 pfet
M$24 out d2 vdd vdd pfet L=0.3U W=4.635U AS=1.9467P AD=1.9467P PS=10.11U
+ PD=10.11U
* device instance $25 r0 *1 74.35,-27.683 pfet
M$25 out d2 vdd vdd pfet L=0.3U W=4.635U AS=1.9467P AD=1.9467P PS=10.11U
+ PD=10.11U
* device instance $26 r0 *1 75.89,-27.683 pfet
M$26 out d2 vdd vdd pfet L=0.3U W=4.635U AS=1.9467P AD=1.9467P PS=10.11U
+ PD=10.11U
* device instance $27 r0 *1 77.43,-27.683 pfet
M$27 out d2 vdd vdd pfet L=0.3U W=4.635U AS=1.9467P AD=1.9467P PS=10.11U
+ PD=10.11U
* device instance $28 r0 *1 54.57,0.772 pfet
M$28 d1 d1 vdd vdd pfet L=0.3U W=1.545U AS=0.6489P AD=0.6489P PS=3.93U PD=3.93U
* device instance $29 r0 *1 56.11,0.772 pfet
M$29 d2 d1 vdd vdd pfet L=0.3U W=1.545U AS=0.6489P AD=0.6489P PS=3.93U PD=3.93U
* device instance $30 r0 *1 57.65,0.772 pfet
M$30 d1 d1 vdd vdd pfet L=0.3U W=1.545U AS=0.6489P AD=0.6489P PS=3.93U PD=3.93U
* device instance $31 r0 *1 54.57,3.537 pfet
M$31 d2 d1 vdd vdd pfet L=0.3U W=1.545U AS=0.6489P AD=0.6489P PS=3.93U PD=3.93U
* device instance $32 r0 *1 56.11,3.537 pfet
M$32 d1 d1 vdd vdd pfet L=0.3U W=1.545U AS=0.6489P AD=0.6489P PS=3.93U PD=3.93U
* device instance $33 r0 *1 57.65,3.537 pfet
M$33 d2 d1 vdd vdd pfet L=0.3U W=1.545U AS=0.6489P AD=0.6489P PS=3.93U PD=3.93U
* device instance $34 r0 *1 103.31,-21.69 sky130_fd_pr__model__cap_mim
C$34 out cz 4.9984e-13
* device instance $35 r0 *1 102.307,-7.295 res_high_po
X$35 d2 cz vss res_high_po r=2629.30659215 L=9.765U W=1.41U
.ENDS opamp_core
